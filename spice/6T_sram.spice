** sch_path: /home/thilak-t/Desktop/Sram_Dram/6T_sram.sch
**.subckt 6T_sram vdd blb bl wl qb q
*.ipin vdd
*.ipin blb
*.ipin bl
*.ipin wl
*.opin qb
*.opin q
XM1 qb q vdd vdd sky130_fd_pr__pfet_01v8 L=0.15 W=1 nf=1 ad=0.29 as=0.29 pd=2.58 ps=2.58 nrd=0.29 nrs=0.29 sa=0 sb=0 sd=0 mult=1
XM2 qb q gnd gnd sky130_fd_pr__nfet_01v8 L=0.15 W=1 nf=1 ad=0.29 as=0.29 pd=2.58 ps=2.58 nrd=0.29 nrs=0.29 sa=0 sb=0 sd=0 mult=1
XM3 q qb vdd vdd sky130_fd_pr__pfet_01v8 L=0.15 W=1 nf=1 ad=0.29 as=0.29 pd=2.58 ps=2.58 nrd=0.29 nrs=0.29 sa=0 sb=0 sd=0 mult=1
XM4 q qb gnd gnd sky130_fd_pr__nfet_01v8 L=0.15 W=1 nf=1 ad=0.29 as=0.29 pd=2.58 ps=2.58 nrd=0.29 nrs=0.29 sa=0 sb=0 sd=0 mult=1
XM5 qb wl blb gnd sky130_fd_pr__nfet_01v8 L=0.15 W=1 nf=1 ad=0.29 as=0.29 pd=2.58 ps=2.58 nrd=0.29 nrs=0.29 sa=0 sb=0 sd=0 mult=1
XM6 q wl bl gnd sky130_fd_pr__nfet_01v8 L=0.15 W=1 nf=1 ad=0.29 as=0.29 pd=2.58 ps=2.58 nrd=0.29 nrs=0.29 sa=0 sb=0 sd=0 mult=1
V1 vdd gnd dc 1.8
V2 blb gnd PULSE(1.8 0 0ns 60ps 60ps 5ns 10ns)
V3 bl gnd PULSE(0 1.8 0ns 60ps 60ps 5ns 10ns)
V5 wl gnd dc 1.8
**** begin user architecture code

.tran 1e-09 20e-09 0e-00
.control
run
plot wl bl-12 blb-10 q-6 qb-11

.endc
.end

.lib /home/thilak-t/Desktop/eda_tools/open_pdks/sky130/sky130A/libs.tech/combined/sky130.lib.spice tt
**** end user architecture code
**.ends
.GLOBAL gnd
.end
