** sch_path: /home/thilak-t/Desktop/Sram_Dram/sram_snm.sch
**.subckt sram_snm qb q vdd
*.opin qb
*.opin q
*.ipin vdd
XM1 qb net2 vdd vdd sky130_fd_pr__pfet_01v8 L=0.15 W=1 nf=1 ad=0.29 as=0.29 pd=2.58 ps=2.58 nrd=0.29 nrs=0.29 sa=0 sb=0 sd=0
+ mult=1
XM2 qb net2 gnd gnd sky130_fd_pr__nfet_01v8 L=0.15 W=0.42 nf=1 ad=0.1218 as=0.1218 pd=1.42 ps=1.42 nrd=0.69047619047619
+ nrs=0.69047619047619 sa=0 sb=0 sd=0 mult=1
XM3 q net1 vdd vdd sky130_fd_pr__pfet_01v8 L=0.15 W=1 nf=1 ad=0.29 as=0.29 pd=2.58 ps=2.58 nrd=0.29 nrs=0.29 sa=0 sb=0 sd=0 mult=1
XM4 q net1 gnd gnd sky130_fd_pr__nfet_01v8 L=0.15 W=0.42 nf=1 ad=0.1218 as=0.1218 pd=1.42 ps=1.42 nrd=0.69047619047619
+ nrs=0.69047619047619 sa=0 sb=0 sd=0 mult=1
V1 net2 gnd dc 0
V2 net1 gnd dc 0
vdd vdd gnd dc 1.8
**** begin user architecture code

.dc V2 0 1.8 0.005 V1 0 1.8 0.005
.control
run
plot v(qb) vs v(net2) v(net1) vs v(q)
.endc

.end

.lib /home/thilak-t/Desktop/eda_tools/open_pdks/sky130/sky130A/libs.tech/combined/sky130.lib.spice tt
**** end user architecture code
**.ends
.GLOBAL gnd
.end
